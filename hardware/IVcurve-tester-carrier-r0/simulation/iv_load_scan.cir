IV Curve Tester carrier r0 - static 16-channel load scan

* User-adjustable DUT and front-end assumptions.
* SOURCE_MODE=0: Thevenin source, VOC in series with RSRC.
* SOURCE_MODE=1: equivalent Norton source, VOC/RSRC in parallel with RSRC.
.param SOURCE_MODE=0
.param VOC=3.3
.param RSRC=22
.param RON=6
.param VADC_SUPPLY=3.3
.param ADC_RSER=1k
.param ADC_RIN=10Meg
.param ADC_CIN=5p
.param RESISTOR_RATING=0.25

* Draft nominal load bank from CONNECTION_MATRIX.md.
.param RCH0=1Meg
.param RCH1=20k
.param RCH2=8.2k
.param RCH3=4.3k
.param RCH4=2.2k
.param RCH5=1k
.param RCH6=750
.param RCH7=470
.param RCH8=330
.param RCH9=220
.param RCH10=150
.param RCH11=100
.param RCH12=82
.param RCH13=51
.param RCH14=30
.param RCH15=18

* The ADC model is intentionally simple: 1 kohm sense lead, 10 Mohm
* input resistance, 5 pF placeholder capacitance, and rail clamps.
VADC vdd 0 {VADC_SUPPLY}
.model DCLAMP D(Is=1e-15 N=1 Rs=1 Cjo=1p)

* Each block is an independent replica of the same DUT.  This is equivalent
* to a static one-channel-at-a-time MUX scan; it does not model switch timing.

* Channel 0 / S1 / 1 Mohm
VTH0 th0 0 {VOC*(1-SOURCE_MODE)}
RTH0 th0 dut0 {RSRC + SOURCE_MODE*1e12}
IN0 0 dut0 dc {SOURCE_MODE*VOC/RSRC}
RN0 dut0 0 {RSRC + (1-SOURCE_MODE)*1e12}
RLOAD0 dut0 mux0 {RCH0}
VMEAS0 mux0 ron0 0
RRON0 ron0 0 {RON}
RADC_SER0 dut0 adc0 {ADC_RSER}
RADC_IN0 adc0 0 {ADC_RIN}
CADC0 adc0 0 {ADC_CIN}
DADC_HI0 adc0 vdd DCLAMP
DADC_LO0 0 adc0 DCLAMP

* Channel 1 / S2 / 20 kohm
VTH1 th1 0 {VOC*(1-SOURCE_MODE)}
RTH1 th1 dut1 {RSRC + SOURCE_MODE*1e12}
IN1 0 dut1 dc {SOURCE_MODE*VOC/RSRC}
RN1 dut1 0 {RSRC + (1-SOURCE_MODE)*1e12}
RLOAD1 dut1 mux1 {RCH1}
VMEAS1 mux1 ron1 0
RRON1 ron1 0 {RON}
RADC_SER1 dut1 adc1 {ADC_RSER}
RADC_IN1 adc1 0 {ADC_RIN}
CADC1 adc1 0 {ADC_CIN}
DADC_HI1 adc1 vdd DCLAMP
DADC_LO1 0 adc1 DCLAMP

* Channel 2 / S3 / 8.2 kohm
VTH2 th2 0 {VOC*(1-SOURCE_MODE)}
RTH2 th2 dut2 {RSRC + SOURCE_MODE*1e12}
IN2 0 dut2 dc {SOURCE_MODE*VOC/RSRC}
RN2 dut2 0 {RSRC + (1-SOURCE_MODE)*1e12}
RLOAD2 dut2 mux2 {RCH2}
VMEAS2 mux2 ron2 0
RRON2 ron2 0 {RON}
RADC_SER2 dut2 adc2 {ADC_RSER}
RADC_IN2 adc2 0 {ADC_RIN}
CADC2 adc2 0 {ADC_CIN}
DADC_HI2 adc2 vdd DCLAMP
DADC_LO2 0 adc2 DCLAMP

* Channel 3 / S4 / 4.3 kohm
VTH3 th3 0 {VOC*(1-SOURCE_MODE)}
RTH3 th3 dut3 {RSRC + SOURCE_MODE*1e12}
IN3 0 dut3 dc {SOURCE_MODE*VOC/RSRC}
RN3 dut3 0 {RSRC + (1-SOURCE_MODE)*1e12}
RLOAD3 dut3 mux3 {RCH3}
VMEAS3 mux3 ron3 0
RRON3 ron3 0 {RON}
RADC_SER3 dut3 adc3 {ADC_RSER}
RADC_IN3 adc3 0 {ADC_RIN}
CADC3 adc3 0 {ADC_CIN}
DADC_HI3 adc3 vdd DCLAMP
DADC_LO3 0 adc3 DCLAMP

* Channel 4 / S5 / 2.2 kohm
VTH4 th4 0 {VOC*(1-SOURCE_MODE)}
RTH4 th4 dut4 {RSRC + SOURCE_MODE*1e12}
IN4 0 dut4 dc {SOURCE_MODE*VOC/RSRC}
RN4 dut4 0 {RSRC + (1-SOURCE_MODE)*1e12}
RLOAD4 dut4 mux4 {RCH4}
VMEAS4 mux4 ron4 0
RRON4 ron4 0 {RON}
RADC_SER4 dut4 adc4 {ADC_RSER}
RADC_IN4 adc4 0 {ADC_RIN}
CADC4 adc4 0 {ADC_CIN}
DADC_HI4 adc4 vdd DCLAMP
DADC_LO4 0 adc4 DCLAMP

* Channel 5 / S6 / 1 kohm
VTH5 th5 0 {VOC*(1-SOURCE_MODE)}
RTH5 th5 dut5 {RSRC + SOURCE_MODE*1e12}
IN5 0 dut5 dc {SOURCE_MODE*VOC/RSRC}
RN5 dut5 0 {RSRC + (1-SOURCE_MODE)*1e12}
RLOAD5 dut5 mux5 {RCH5}
VMEAS5 mux5 ron5 0
RRON5 ron5 0 {RON}
RADC_SER5 dut5 adc5 {ADC_RSER}
RADC_IN5 adc5 0 {ADC_RIN}
CADC5 adc5 0 {ADC_CIN}
DADC_HI5 adc5 vdd DCLAMP
DADC_LO5 0 adc5 DCLAMP

* Channel 6 / S7 / 750 ohm
VTH6 th6 0 {VOC*(1-SOURCE_MODE)}
RTH6 th6 dut6 {RSRC + SOURCE_MODE*1e12}
IN6 0 dut6 dc {SOURCE_MODE*VOC/RSRC}
RN6 dut6 0 {RSRC + (1-SOURCE_MODE)*1e12}
RLOAD6 dut6 mux6 {RCH6}
VMEAS6 mux6 ron6 0
RRON6 ron6 0 {RON}
RADC_SER6 dut6 adc6 {ADC_RSER}
RADC_IN6 adc6 0 {ADC_RIN}
CADC6 adc6 0 {ADC_CIN}
DADC_HI6 adc6 vdd DCLAMP
DADC_LO6 0 adc6 DCLAMP

* Channel 7 / S8 / 470 ohm
VTH7 th7 0 {VOC*(1-SOURCE_MODE)}
RTH7 th7 dut7 {RSRC + SOURCE_MODE*1e12}
IN7 0 dut7 dc {SOURCE_MODE*VOC/RSRC}
RN7 dut7 0 {RSRC + (1-SOURCE_MODE)*1e12}
RLOAD7 dut7 mux7 {RCH7}
VMEAS7 mux7 ron7 0
RRON7 ron7 0 {RON}
RADC_SER7 dut7 adc7 {ADC_RSER}
RADC_IN7 adc7 0 {ADC_RIN}
CADC7 adc7 0 {ADC_CIN}
DADC_HI7 adc7 vdd DCLAMP
DADC_LO7 0 adc7 DCLAMP

* Channel 8 / S9 / 330 ohm
VTH8 th8 0 {VOC*(1-SOURCE_MODE)}
RTH8 th8 dut8 {RSRC + SOURCE_MODE*1e12}
IN8 0 dut8 dc {SOURCE_MODE*VOC/RSRC}
RN8 dut8 0 {RSRC + (1-SOURCE_MODE)*1e12}
RLOAD8 dut8 mux8 {RCH8}
VMEAS8 mux8 ron8 0
RRON8 ron8 0 {RON}
RADC_SER8 dut8 adc8 {ADC_RSER}
RADC_IN8 adc8 0 {ADC_RIN}
CADC8 adc8 0 {ADC_CIN}
DADC_HI8 adc8 vdd DCLAMP
DADC_LO8 0 adc8 DCLAMP

* Channel 9 / S10 / 220 ohm
VTH9 th9 0 {VOC*(1-SOURCE_MODE)}
RTH9 th9 dut9 {RSRC + SOURCE_MODE*1e12}
IN9 0 dut9 dc {SOURCE_MODE*VOC/RSRC}
RN9 dut9 0 {RSRC + (1-SOURCE_MODE)*1e12}
RLOAD9 dut9 mux9 {RCH9}
VMEAS9 mux9 ron9 0
RRON9 ron9 0 {RON}
RADC_SER9 dut9 adc9 {ADC_RSER}
RADC_IN9 adc9 0 {ADC_RIN}
CADC9 adc9 0 {ADC_CIN}
DADC_HI9 adc9 vdd DCLAMP
DADC_LO9 0 adc9 DCLAMP

* Channel 10 / S11 / 150 ohm
VTH10 th10 0 {VOC*(1-SOURCE_MODE)}
RTH10 th10 dut10 {RSRC + SOURCE_MODE*1e12}
IN10 0 dut10 dc {SOURCE_MODE*VOC/RSRC}
RN10 dut10 0 {RSRC + (1-SOURCE_MODE)*1e12}
RLOAD10 dut10 mux10 {RCH10}
VMEAS10 mux10 ron10 0
RRON10 ron10 0 {RON}
RADC_SER10 dut10 adc10 {ADC_RSER}
RADC_IN10 adc10 0 {ADC_RIN}
CADC10 adc10 0 {ADC_CIN}
DADC_HI10 adc10 vdd DCLAMP
DADC_LO10 0 adc10 DCLAMP

* Channel 11 / S12 / 100 ohm
VTH11 th11 0 {VOC*(1-SOURCE_MODE)}
RTH11 th11 dut11 {RSRC + SOURCE_MODE*1e12}
IN11 0 dut11 dc {SOURCE_MODE*VOC/RSRC}
RN11 dut11 0 {RSRC + (1-SOURCE_MODE)*1e12}
RLOAD11 dut11 mux11 {RCH11}
VMEAS11 mux11 ron11 0
RRON11 ron11 0 {RON}
RADC_SER11 dut11 adc11 {ADC_RSER}
RADC_IN11 adc11 0 {ADC_RIN}
CADC11 adc11 0 {ADC_CIN}
DADC_HI11 adc11 vdd DCLAMP
DADC_LO11 0 adc11 DCLAMP

* Channel 12 / S13 / 82 ohm
VTH12 th12 0 {VOC*(1-SOURCE_MODE)}
RTH12 th12 dut12 {RSRC + SOURCE_MODE*1e12}
IN12 0 dut12 dc {SOURCE_MODE*VOC/RSRC}
RN12 dut12 0 {RSRC + (1-SOURCE_MODE)*1e12}
RLOAD12 dut12 mux12 {RCH12}
VMEAS12 mux12 ron12 0
RRON12 ron12 0 {RON}
RADC_SER12 dut12 adc12 {ADC_RSER}
RADC_IN12 adc12 0 {ADC_RIN}
CADC12 adc12 0 {ADC_CIN}
DADC_HI12 adc12 vdd DCLAMP
DADC_LO12 0 adc12 DCLAMP

* Channel 13 / S14 / 51 ohm
VTH13 th13 0 {VOC*(1-SOURCE_MODE)}
RTH13 th13 dut13 {RSRC + SOURCE_MODE*1e12}
IN13 0 dut13 dc {SOURCE_MODE*VOC/RSRC}
RN13 dut13 0 {RSRC + (1-SOURCE_MODE)*1e12}
RLOAD13 dut13 mux13 {RCH13}
VMEAS13 mux13 ron13 0
RRON13 ron13 0 {RON}
RADC_SER13 dut13 adc13 {ADC_RSER}
RADC_IN13 adc13 0 {ADC_RIN}
CADC13 adc13 0 {ADC_CIN}
DADC_HI13 adc13 vdd DCLAMP
DADC_LO13 0 adc13 DCLAMP

* Channel 14 / S15 / 30 ohm
VTH14 th14 0 {VOC*(1-SOURCE_MODE)}
RTH14 th14 dut14 {RSRC + SOURCE_MODE*1e12}
IN14 0 dut14 dc {SOURCE_MODE*VOC/RSRC}
RN14 dut14 0 {RSRC + (1-SOURCE_MODE)*1e12}
RLOAD14 dut14 mux14 {RCH14}
VMEAS14 mux14 ron14 0
RRON14 ron14 0 {RON}
RADC_SER14 dut14 adc14 {ADC_RSER}
RADC_IN14 adc14 0 {ADC_RIN}
CADC14 adc14 0 {ADC_CIN}
DADC_HI14 adc14 vdd DCLAMP
DADC_LO14 0 adc14 DCLAMP

* Channel 15 / S16 / 18 ohm
VTH15 th15 0 {VOC*(1-SOURCE_MODE)}
RTH15 th15 dut15 {RSRC + SOURCE_MODE*1e12}
IN15 0 dut15 dc {SOURCE_MODE*VOC/RSRC}
RN15 dut15 0 {RSRC + (1-SOURCE_MODE)*1e12}
RLOAD15 dut15 mux15 {RCH15}
VMEAS15 mux15 ron15 0
RRON15 ron15 0 {RON}
RADC_SER15 dut15 adc15 {ADC_RSER}
RADC_IN15 adc15 0 {ADC_RIN}
CADC15 adc15 0 {ADC_CIN}
DADC_HI15 adc15 vdd DCLAMP
DADC_LO15 0 adc15 DCLAMP

.options reltol=1e-6 abstol=1p vntol=1u temp=25
.op
.end
